* ======================================================
* CE AMPLIFIER SENSITIVITY SIMULATION
* Run: Representative_3_baseline
* ======================================================

.include "C:/Internship Project/ce_amplifier_dataset/models/2N3904.lib"
.options TEMP=27 TNOM=27

VCC vcc 0 DC 8.31342930236
VIN in 0 DC 0 AC 1
R1 vcc base 400436.250906
R2 base 0 700993.446705
RC vcc coll 3284.59066121
RE emit 0 2141.04231481
Cin in base 8.74242286469e-05
Cout coll out 3.10098344998e-06
Ce emit 0 1.04998491422e-07
RL out 0 2300.94030135
Q1 coll base emit 2N3904

.control
set noaskquit
op
ac dec 20 10 1000000000
wrdata "Representative_3_baseline_gain.txt" vdb(out)
quit
.endc
.end
