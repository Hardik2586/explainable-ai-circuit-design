CE Amplifier - AC Analysis

.include "C:/Internship Project/spice/models/2N3904.lib"

* Power Supply
Vcc VCC 0 DC 14.87540528

* Input AC Source
Vin IN 0 DC 0 AC 1

* Input Coupling Capacitor
Cin IN BASE 5.488060838e-06

* Bias Network
R1 VCC BASE 26179.34833
R2 BASE 0 14576.82077

* Transistor
Q1 COLL BASE EMIT 2N3904

* Collector Resistor
RC1 VCC COLL 2964.553917

* Emitter Resistor and Bypass
RE1 EMIT 0 4501.708793
CE1 EMIT 0 6.036284026e-05

* Output Coupling Capacitor
Cout COLL OUT 9.755549691e-09

* Load Resistor
RL1 OUT 0 24113.79721

* Temperature
.options TEMP=27.0

* DC Operating Point & AC Analysis
.control
op
print v(base)
print v(emit)
print v(coll)
print @q1[ib]
print @q1[ic]
print @q1[ie]
ac dec 20 10 1000000000
wrdata ac_gain.txt vdb(out)
wrdata ac_phase.txt vp(out)
quit
.endc

.end
