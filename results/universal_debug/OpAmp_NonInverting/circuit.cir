* ==================================================
* Universal Circuit-XAI SPICE Netlist
* ==================================================
* Circuit: OpAmp_NonInverting
* Topology: OpAmp_NonInverting
* Generated: 12-Oct-2026 21:58:03
* ==================================================

VCC VCC GND DC 15
VIN IN GND DC 0 AC 1 0
RF OUT NEG 100000
RG NEG GND 10000
E_U1 OUT GND IN NEG 1e6

* ==================================================
* ANALYSIS
* ==================================================
.ac dec 50 10 1000000
.print ac frequency

.end
