* ==================================================
* Universal Circuit-XAI SPICE Netlist
* ==================================================
* Circuit: RC_LowPass
* Topology: RC_LowPass
* Generated: 12-Oct-2026 22:06:15
* ==================================================

VIN IN GND DC 0 AC 1 0
R1 IN OUT 10000
C1 OUT GND 1e-07

* ==================================================
* ANALYSIS
* ==================================================
.ac dec 50 10 1000000
.print ac v(OUT) frequency

.end
